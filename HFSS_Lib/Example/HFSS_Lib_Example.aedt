# Ansys Electronics Desktop project, version 2018.1
materials:
  vacuum: permittivity=1
  air: permittivity=1.0006 permeability=1.0000004
  silicon_dioxide: permittivity=4
  aluminum: permeability=1.000021 conductivity=38000000

design HFSSDesign1 (HFSS, DrivenModal, model units um)
options: Allow_Material_Override
variables:
  TRL_L1 = 40um
  TRL_Lo1 = 40um
  TRL_W = 2um
  TRL_th = 1um
  TRL_elv = 3um
  TRL_SW = 2um
  TRL_Sh = 4um
  TRL_gh = 0.1um
  TRL_S = 4um
  Ring_r = 50um
  Ring_LL = 10um
  NoS = 0
geometry:
  Air [air] = box(corner=(-1mm, -1mm, -250000nm), size=(2mm, 2mm, 1250000nm))
  Oxide [silicon_dioxide] = box(corner=(-1mm, -1mm, 0um), size=(2mm, 2mm, 2um))
  Line1_ [aluminum] = polyline(((TRL_W/2+TRL_S+TRL_SW)*sin(-PI*3/2), (TRL_W/2+TRL_S+TRL_SW)*cos(-PI*3/2), TRL_elv+TRL_th/2), AngularArc from point 0 over 3 centre=(0, 0, TRL_elv+TRL_th/2) angle=-PI/2 plane=XY, section rectangle width=TRL_W height=TRL_th)
  Line1_.move(0, 0, 0)
  Line1_Sa [aluminum] = polyline(((TRL_SW/2)*sin(-PI*3/2), (TRL_SW/2)*cos(-PI*3/2), 0+TRL_Sh/2), AngularArc from point 0 over 3 centre=(0, 0, 0+TRL_Sh/2) angle=-PI/2 plane=XY, section rectangle width=TRL_SW height=TRL_Sh)
  Line1_Sa.move(0, 0, 0)
  Line1_Sb [aluminum] = polyline(((1.5*TRL_SW+TRL_W+2*TRL_S)*sin(-PI*3/2), (1.5*TRL_SW+TRL_W+2*TRL_S)*cos(-PI*3/2), 0+TRL_Sh/2), AngularArc from point 0 over 3 centre=(0, 0, 0+TRL_Sh/2) angle=-PI/2 plane=XY, section rectangle width=TRL_SW height=TRL_Sh)
  Line1_Sb.move(0, 0, 0)
  Line1_Sg [aluminum] = polyline(((TRL_W/2+TRL_S+TRL_SW)*sin(-PI*3/2), (TRL_W/2+TRL_S+TRL_SW)*cos(-PI*3/2), 0+TRL_gh/2), AngularArc from point 0 over 3 centre=(0, 0, 0+TRL_gh/2) angle=-PI/2 plane=XY, section rectangle width=TRL_W+2*TRL_S height=TRL_gh)
  Line1_Sg.move(0, 0, 0)
  Line2_ [aluminum] = box(corner=((-TRL_W/2), 0, TRL_elv), size=(TRL_W, TRL_L1, TRL_th))
  Line2_Sa [aluminum] = box(corner=(-(TRL_W/2+TRL_S+TRL_SW), 0, 0), size=(TRL_SW, TRL_L1, TRL_Sh))
  Line2_Sb [aluminum] = box(corner=((TRL_W/2+TRL_S), 0, 0), size=(TRL_SW, TRL_L1, TRL_Sh))
  Line2_Sg [aluminum] = box(corner=(-(TRL_W/2+TRL_S), 0, 0), size=(2*TRL_S+TRL_W, TRL_L1, TRL_gh))
  [Line2_, Line2_Sa, Line2_Sb, Line2_Sg].rotate(axis=Z, angle=PI/2)
  [Line2_, Line2_Sa, Line2_Sb, Line2_Sg].move(0, -(TRL_W/2+TRL_S+TRL_SW), 0)
  OpenStub1_ [aluminum] = box(corner=((-TRL_W/2), 0, TRL_elv), size=(TRL_W, TRL_Lo1, TRL_th))
  OpenStub1_Sa [aluminum] = box(corner=(-(TRL_W/2+TRL_S+TRL_SW), 0, 0), size=(TRL_SW, TRL_Lo1, TRL_Sh))
  OpenStub1_Sb [aluminum] = box(corner=((TRL_W/2+TRL_S), 0, 0), size=(TRL_SW, TRL_Lo1, TRL_Sh))
  OpenStub1_Sg [aluminum] = box(corner=(-(TRL_W/2+TRL_S), 0, 0), size=(2*TRL_S+TRL_W, TRL_Lo1, TRL_gh))
  [OpenStub1_, OpenStub1_Sa, OpenStub1_Sb, OpenStub1_Sg].rotate(axis=Z, angle=PI)
  [OpenStub1_, OpenStub1_Sa, OpenStub1_Sb, OpenStub1_Sg].move(-(TRL_L1+(TRL_W/2+TRL_S+TRL_SW)), -2*(TRL_W/2+TRL_S+TRL_SW), 0)
  T1_a [aluminum] = box(corner=((-TRL_W/2), 0, TRL_elv), size=(TRL_W, TRL_SW+TRL_S+TRL_W/2, TRL_th))
  T1_b [aluminum] = box(corner=(-(TRL_W/2+TRL_S+TRL_SW), TRL_SW+TRL_S, TRL_elv), size=(2*(TRL_W/2+TRL_S+TRL_SW), TRL_W, TRL_th))
  T1_Sa [aluminum] = box(corner=(-(TRL_W/2+TRL_S+TRL_SW), TRL_SW+2*TRL_S+TRL_W, 0), size=(2*(TRL_W/2+TRL_S+TRL_SW), TRL_SW, TRL_Sh))
  T1_Sb [aluminum] = box(corner=(-(TRL_W/2+TRL_S+TRL_SW), 0, 0), size=(TRL_SW, TRL_SW, TRL_Sh))
  T1_Sc [aluminum] = box(corner=((TRL_W/2+TRL_S), 0, 0), size=(TRL_SW, TRL_SW, TRL_Sh))
  T1_Sg [aluminum] = box(corner=(-(TRL_W/2+TRL_S+TRL_SW), 0, 0), size=(2*(TRL_W/2+TRL_S+TRL_SW), 2*(TRL_SW+TRL_S+TRL_W/2), TRL_gh))
  [T1_a, T1_b, T1_Sa, T1_Sb, T1_Sc, T1_Sg].move(-(TRL_L1+(TRL_W/2+TRL_S+TRL_SW)), -2*(TRL_W/2+TRL_S+TRL_SW), 0)
  ring_line_0 [aluminum] = box(corner=(-(TRL_L1+2*(TRL_W/2+TRL_S+TRL_SW)+TRL_S+TRL_W/2), -((TRL_W/2+TRL_S+TRL_SW)+TRL_W/2), TRL_elv), size=(TRL_S+TRL_W/2, TRL_W, TRL_th))
  Ring1 [aluminum] = cylinder(axis=Z, base_centre=(0, 0, TRL_elv), radius=Ring_r+TRL_W/2, height=TRL_th, segments=NoS)
  Ring1b = cylinder(axis=Z, base_centre=(0, 0, TRL_elv), radius=Ring_r-TRL_W/2, height=TRL_th, segments=NoS)
  Ring1.subtract(Ring1b)
  Ring_line_1 [aluminum] = box(corner=((-TRL_W/2), Ring_r, TRL_elv), size=(TRL_W, Ring_LL, TRL_th))
  Ring_line_2 [aluminum] = box(corner=((-TRL_W/2), Ring_r, TRL_elv), size=(TRL_W, Ring_LL, TRL_th))
  Ring_line_2.rotate(axis=Z, angle=1*PI/11)
  Ring_line_3 [aluminum] = box(corner=((-TRL_W/2), Ring_r, TRL_elv), size=(TRL_W, Ring_LL, TRL_th))
  Ring_line_3.rotate(axis=Z, angle=2*PI/11)
  Ring_line_4 [aluminum] = box(corner=((-TRL_W/2), Ring_r, TRL_elv), size=(TRL_W, Ring_LL, TRL_th))
  Ring_line_4.rotate(axis=Z, angle=3*PI/11)
  Ring_line_5 [aluminum] = box(corner=((-TRL_W/2), Ring_r, TRL_elv), size=(TRL_W, Ring_LL, TRL_th))
  Ring_line_5.rotate(axis=Z, angle=4*PI/11)
  Ring_line_6 [aluminum] = box(corner=((-TRL_W/2), Ring_r, TRL_elv), size=(TRL_W, Ring_LL, TRL_th))
  Ring_line_6.rotate(axis=Z, angle=5*PI/11)
  Ring_line_7 [aluminum] = box(corner=((-TRL_W/2), Ring_r, TRL_elv), size=(TRL_W, Ring_LL, TRL_th))
  Ring_line_7.rotate(axis=Z, angle=6*PI/11)
  Ring_line_8 [aluminum] = box(corner=((-TRL_W/2), Ring_r, TRL_elv), size=(TRL_W, Ring_LL, TRL_th))
  Ring_line_8.rotate(axis=Z, angle=7*PI/11)
  Ring_line_9 [aluminum] = box(corner=((-TRL_W/2), Ring_r, TRL_elv), size=(TRL_W, Ring_LL, TRL_th))
  Ring_line_9.rotate(axis=Z, angle=8*PI/11)
  Ring_line_10 [aluminum] = box(corner=((-TRL_W/2), Ring_r, TRL_elv), size=(TRL_W, Ring_LL, TRL_th))
  Ring_line_10.rotate(axis=Z, angle=9*PI/11)
  Ring_line_11 [aluminum] = box(corner=((-TRL_W/2), Ring_r, TRL_elv), size=(TRL_W, Ring_LL, TRL_th))
  Ring_line_11.rotate(axis=Z, angle=10*PI/11)
  Ring_line_12 [aluminum] = box(corner=((-TRL_W/2), Ring_r, TRL_elv), size=(TRL_W, Ring_LL, TRL_th))
  Ring_line_12.rotate(axis=Z, angle=11*PI/11)
  Ring_sg [aluminum] = box(corner=(-(Ring_r+Ring_LL), -(Ring_r+Ring_LL), 0), size=(2*Ring_r+Ring_LL+TRL_S+TRL_W/2, 2*(Ring_r+Ring_LL), TRL_gh))
  [Ring1, Ring_line_1..Ring_line_12, Ring_sg].move(-(TRL_L1+2*(TRL_W/2+TRL_S+TRL_SW)+TRL_S+Ring_r+TRL_W/2), -(TRL_W/2+TRL_S+TRL_SW), 0)
  group Line1_Group = Line1_, Line1_Sa, Line1_Sb, Line1_Sg
  group Line2_Group = Line2_, Line2_Sa, Line2_Sb, Line2_Sg
  group OpenStub1_Group = OpenStub1_, OpenStub1_Sa, OpenStub1_Sb, OpenStub1_Sg
  group T1_Group = T1_a, T1_b, T1_Sa, T1_Sb, T1_Sc, T1_Sg
  group Ring_Group = Ring1, Ring_line_1..Ring_line_12, Ring_sg
boundaries and excitations:
  Rad1: Radiation Objects=Air
setups:
  Setup250: HfssDriven Frequency=250GHz MaxDeltaE=0.02 MaximumPasses=20 MinimumPasses=2 MinimumConvergedPasses=2 PercentRefinement=30 BasisOrder=1
    sweep Sweep1: 100GHz to 200GHz step 1GHz; Type=Discrete SaveFields
