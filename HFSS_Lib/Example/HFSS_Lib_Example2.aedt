# Ansys Electronics Desktop project, version 2018.1
materials:
  vacuum: permittivity=1
  air: permittivity=1.0006 permeability=1.0000004
  FR4_epoxy: permittivity=4.4 dielectric_loss_tangent=0.02
  copper: permeability=0.999991 conductivity=58000000
  pec: conductivity=1e+30

design HFSSDesign1 (HFSS, DrivenModal, model units mm)
options: Allow_Material_Override
variables:
  SPL_Ld = 4mm
  SPL_dk = 2
  SPL_dA = 0.6mm
  HRO_Lg = 6mm
  HRO_Lso = 5mm
  HRO_Ls = 5mm
  TRL_W = 0.1mm
  TRL_SW = 0.5mm
  TRL_SS = 2.5mm
  WP_h = 10mm
  NoS = 0
  Co_th = 0.6mil
  Dia_th = 0.06in
  Line_elv = Co_th+Dia_th
  Line_th = Co_th
  GND_elv = 0
  GND_th = Co_th
geometry:
  Air [air] = box(corner=(-200mm, -200mm, -250mm), size=(400mm, 400mm, 500mm))
  Substrate [FR4_epoxy] = box(corner=(-20mm, -20mm, GND_elv+GND_th), size=(40mm, 40mm, Dia_th))
  TRL10z [copper] = polyline(z=Line_elv+Line_th/2, xy: (SPL_dA*sin(SPL_dk*0*2*PI/30), 0*(SPL_Ld/30)) (SPL_dA*sin(SPL_dk*1*2*PI/30), 1*(SPL_Ld/30)) (SPL_dA*sin(SPL_dk*2*2*PI/30), 2*(SPL_Ld/30)) (SPL_dA*sin(SPL_dk*3*2*PI/30), 3*(SPL_Ld/30)) (SPL_dA*sin(SPL_dk*4*2*PI/30), 4*(SPL_Ld/30)) (SPL_dA*sin(SPL_dk*5*2*PI/30), 5*(SPL_Ld/30)) (SPL_dA*sin(SPL_dk*6*2*PI/30), 6*(SPL_Ld/30)) (SPL_dA*sin(SPL_dk*7*2*PI/30), 7*(SPL_Ld/30)) (SPL_dA*sin(SPL_dk*8*2*PI/30), 8*(SPL_Ld/30)) (SPL_dA*sin(SPL_dk*9*2*PI/30), 9*(SPL_Ld/30)) (SPL_dA*sin(SPL_dk*10*2*PI/30), 10*(SPL_Ld/30)) (SPL_dA*sin(SPL_dk*11*2*PI/30), 11*(SPL_Ld/30)) (SPL_dA*sin(SPL_dk*12*2*PI/30), 12*(SPL_Ld/30)) (SPL_dA*sin(SPL_dk*13*2*PI/30), 13*(SPL_Ld/30)) (SPL_dA*sin(SPL_dk*14*2*PI/30), 14*(SPL_Ld/30)) (SPL_dA*sin(SPL_dk*15*2*PI/30), 15*(SPL_Ld/30)) (SPL_dA*sin(SPL_dk*16*2*PI/30), 16*(SPL_Ld/30)) (SPL_dA*sin(SPL_dk*17*2*PI/30), 17*(SPL_Ld/30)) (SPL_dA*sin(SPL_dk*18*2*PI/30), 18*(SPL_Ld/30)) (SPL_dA*sin(SPL_dk*19*2*PI/30), 19*(SPL_Ld/30)) (SPL_dA*sin(SPL_dk*20*2*PI/30), 20*(SPL_Ld/30)) (SPL_dA*sin(SPL_dk*21*2*PI/30), 21*(SPL_Ld/30)) (SPL_dA*sin(SPL_dk*22*2*PI/30), 22*(SPL_Ld/30)) (SPL_dA*sin(SPL_dk*23*2*PI/30), 23*(SPL_Ld/30)) (SPL_dA*sin(SPL_dk*24*2*PI/30), 24*(SPL_Ld/30)) (SPL_dA*sin(SPL_dk*25*2*PI/30), 25*(SPL_Ld/30)) (SPL_dA*sin(SPL_dk*26*2*PI/30), 26*(SPL_Ld/30)) (SPL_dA*sin(SPL_dk*27*2*PI/30), 27*(SPL_Ld/30)) (SPL_dA*sin(SPL_dk*28*2*PI/30), 28*(SPL_Ld/30)) (SPL_dA*sin(SPL_dk*29*2*PI/30), 29*(SPL_Ld/30)) (SPL_dA*sin(SPL_dk*30*2*PI/30), 30*(SPL_Ld/30)), Spline from point 0 over 31, section rectangle width=TRL_W height=Line_th)
  TRL10zCa [copper] = cylinder(axis=Z, base_centre=(SPL_dA*sin(SPL_dk*0*2*PI/30), 0*(SPL_Ld/30), Line_elv), radius=TRL_W/2, height=Line_th, segments=NoS)
  TRL10zCb [copper] = cylinder(axis=Z, base_centre=(SPL_dA*sin(SPL_dk*30*2*PI/30), 30*(SPL_Ld/30), Line_elv), radius=TRL_W/2, height=Line_th, segments=NoS)
  TRL10zSa [copper] = box(corner=(-(TRL_SS/2+TRL_SW), 0, Line_elv), size=(TRL_SW, SPL_Ld, Line_th))
  TRL10zSb [copper] = box(corner=((TRL_SS/2), 0, Line_elv), size=(TRL_SW, SPL_Ld, Line_th))
  TRL10zSg [copper] = box(corner=(-(TRL_SS/2+TRL_SW), 0, GND_elv), size=(TRL_SS+2*TRL_SW, SPL_Ld, GND_th))
  TRL11z [copper] = polyline(z=Line_elv+Line_th/2, xy: (SPL_dA*sin(SPL_dk*0*2*PI/30), 0*(SPL_Ld/30)) (SPL_dA*sin(SPL_dk*1*2*PI/30), 1*(SPL_Ld/30)) (SPL_dA*sin(SPL_dk*2*2*PI/30), 2*(SPL_Ld/30)) (SPL_dA*sin(SPL_dk*3*2*PI/30), 3*(SPL_Ld/30)) (SPL_dA*sin(SPL_dk*4*2*PI/30), 4*(SPL_Ld/30)) (SPL_dA*sin(SPL_dk*5*2*PI/30), 5*(SPL_Ld/30)) (SPL_dA*sin(SPL_dk*6*2*PI/30), 6*(SPL_Ld/30)) (SPL_dA*sin(SPL_dk*7*2*PI/30), 7*(SPL_Ld/30)) (SPL_dA*sin(SPL_dk*8*2*PI/30), 8*(SPL_Ld/30)) (SPL_dA*sin(SPL_dk*9*2*PI/30), 9*(SPL_Ld/30)) (SPL_dA*sin(SPL_dk*10*2*PI/30), 10*(SPL_Ld/30)) (SPL_dA*sin(SPL_dk*11*2*PI/30), 11*(SPL_Ld/30)) (SPL_dA*sin(SPL_dk*12*2*PI/30), 12*(SPL_Ld/30)) (SPL_dA*sin(SPL_dk*13*2*PI/30), 13*(SPL_Ld/30)) (SPL_dA*sin(SPL_dk*14*2*PI/30), 14*(SPL_Ld/30)) (SPL_dA*sin(SPL_dk*15*2*PI/30), 15*(SPL_Ld/30)) (SPL_dA*sin(SPL_dk*16*2*PI/30), 16*(SPL_Ld/30)) (SPL_dA*sin(SPL_dk*17*2*PI/30), 17*(SPL_Ld/30)) (SPL_dA*sin(SPL_dk*18*2*PI/30), 18*(SPL_Ld/30)) (SPL_dA*sin(SPL_dk*19*2*PI/30), 19*(SPL_Ld/30)) (SPL_dA*sin(SPL_dk*20*2*PI/30), 20*(SPL_Ld/30)) (SPL_dA*sin(SPL_dk*21*2*PI/30), 21*(SPL_Ld/30)) (SPL_dA*sin(SPL_dk*22*2*PI/30), 22*(SPL_Ld/30)) (SPL_dA*sin(SPL_dk*23*2*PI/30), 23*(SPL_Ld/30)) (SPL_dA*sin(SPL_dk*24*2*PI/30), 24*(SPL_Ld/30)) (SPL_dA*sin(SPL_dk*25*2*PI/30), 25*(SPL_Ld/30)) (SPL_dA*sin(SPL_dk*26*2*PI/30), 26*(SPL_Ld/30)) (SPL_dA*sin(SPL_dk*27*2*PI/30), 27*(SPL_Ld/30)) (SPL_dA*sin(SPL_dk*28*2*PI/30), 28*(SPL_Ld/30)) (SPL_dA*sin(SPL_dk*29*2*PI/30), 29*(SPL_Ld/30)) (SPL_dA*sin(SPL_dk*30*2*PI/30), 30*(SPL_Ld/30)), Spline from point 0 over 31, section rectangle width=TRL_W height=Line_th)
  TRL11zCa [copper] = cylinder(axis=Z, base_centre=(SPL_dA*sin(SPL_dk*0*2*PI/30), 0*(SPL_Ld/30), Line_elv), radius=TRL_W/2, height=Line_th, segments=NoS)
  TRL11zCb [copper] = cylinder(axis=Z, base_centre=(SPL_dA*sin(SPL_dk*30*2*PI/30), 30*(SPL_Ld/30), Line_elv), radius=TRL_W/2, height=Line_th, segments=NoS)
  TRL11zSa [copper] = box(corner=(-(TRL_SS/2+TRL_SW), 0, Line_elv), size=(TRL_SW, SPL_Ld, Line_th))
  TRL11zSb [copper] = box(corner=((TRL_SS/2), 0, Line_elv), size=(TRL_SW, SPL_Ld, Line_th))
  TRL11zSg [copper] = box(corner=(-(TRL_SS/2+TRL_SW), 0, GND_elv), size=(TRL_SS+2*TRL_SW, SPL_Ld, GND_th))
  [TRL11z, TRL11zCa, TRL11zCb, TRL11zSa, TRL11zSb, TRL11zSg].move(0, -SPL_Ld, 0)
  TRL12z [copper] = box(corner=((-TRL_W/2), 0, Line_elv), size=(TRL_W, -(2*SPL_Ld+(TRL_SS+2*TRL_SW)), Line_th))
  TRL12zSa [copper] = box(corner=(-((TRL_SS)/2+TRL_SW), 0, Line_elv), size=(TRL_SW, -(2*SPL_Ld+(TRL_SS+2*TRL_SW)), Line_th))
  TRL12zSb [copper] = box(corner=(((TRL_SS)/2), 0, Line_elv), size=(TRL_SW, -(2*SPL_Ld+(TRL_SS+2*TRL_SW)), Line_th))
  TRL12zSg [copper] = box(corner=(-((TRL_SS)/2+TRL_SW), 0, GND_elv), size=(TRL_SS+2*TRL_SW, -(2*SPL_Ld+(TRL_SS+2*TRL_SW)), GND_th))
  [TRL12z, TRL12zSa, TRL12zSb, TRL12zSg].move(-((TRL_SS+2*TRL_SW)), SPL_Ld, 0)
  TRL13z [copper] = polyline(((TRL_SS/2+TRL_SW+(0))*sin(PI+(PI)), (TRL_SS/2+TRL_SW+(0))*cos(PI+(PI)), Line_elv+(Line_th)/2), AngularArc from point 0 over 3 centre=(0, 0, Line_elv+(Line_th)/2) angle=(PI) plane=XY, section rectangle width=TRL_W height=Line_th)
  TRL13z.move(0, 0, 0)
  TRL13zSa [copper] = polyline(((TRL_SW/2+(0))*sin(PI+(PI)), (TRL_SW/2+(0))*cos(PI+(PI)), Line_elv+(Line_th)/2), AngularArc from point 0 over 3 centre=(0, 0, Line_elv+(Line_th)/2) angle=(PI) plane=XY, section rectangle width=TRL_SW height=Line_th)
  TRL13zSa.move(0, 0, 0)
  TRL13zSb [copper] = polyline(((1.5*TRL_SW+TRL_SS+(0))*sin(PI+(PI)), (1.5*TRL_SW+TRL_SS+(0))*cos(PI+(PI)), Line_elv+(Line_th)/2), AngularArc from point 0 over 3 centre=(0, 0, Line_elv+(Line_th)/2) angle=(PI) plane=XY, section rectangle width=TRL_SW height=Line_th)
  TRL13zSb.move(0, 0, 0)
  TRL13zSg [copper] = polyline(((TRL_SS/2+TRL_SW+(0))*sin(PI+(PI)), (TRL_SS/2+TRL_SW+(0))*cos(PI+(PI)), GND_elv+(GND_th)/2), AngularArc from point 0 over 3 centre=(0, 0, GND_elv+(GND_th)/2) angle=(PI) plane=XY, section rectangle width=TRL_SS+2*TRL_SW-0.1um height=GND_th)
  TRL13zSg.move(0, 0, 0)
  [TRL13z, TRL13zSa, TRL13zSb, TRL13zSg].rotate(axis=Z, angle=-PI/2)
  [TRL13z, TRL13zSa, TRL13zSb, TRL13zSg].move(-((TRL_SS+2*TRL_SW)-(TRL_SS+2*TRL_SW)/2), SPL_Ld, 0)
  TRL14z [copper] = box(corner=((-TRL_W/2), 0, Line_elv), size=(TRL_W, (2*SPL_Ld+(TRL_SS+2*TRL_SW)), Line_th))
  TRL14zSa [copper] = box(corner=(-((TRL_SS)/2+TRL_SW), 0, Line_elv), size=(TRL_SW, (2*SPL_Ld+(TRL_SS+2*TRL_SW)), Line_th))
  TRL14zSb [copper] = box(corner=(((TRL_SS)/2), 0, Line_elv), size=(TRL_SW, (2*SPL_Ld+(TRL_SS+2*TRL_SW)), Line_th))
  TRL14zSg [copper] = box(corner=(-((TRL_SS)/2+TRL_SW), 0, GND_elv), size=(TRL_SS+2*TRL_SW, (2*SPL_Ld+(TRL_SS+2*TRL_SW)), GND_th))
  [TRL14z, TRL14zSa, TRL14zSb, TRL14zSg].move(((TRL_SS+2*TRL_SW)), -SPL_Ld, 0)
  TRL15z [copper] = polyline(((TRL_SS/2+TRL_SW+(0))*sin(PI+(PI)), (TRL_SS/2+TRL_SW+(0))*cos(PI+(PI)), Line_elv+(Line_th)/2), AngularArc from point 0 over 3 centre=(0, 0, Line_elv+(Line_th)/2) angle=(PI) plane=XY, section rectangle width=TRL_W height=Line_th)
  TRL15z.move(0, 0, 0)
  TRL15zSa [copper] = polyline(((TRL_SW/2+(0))*sin(PI+(PI)), (TRL_SW/2+(0))*cos(PI+(PI)), Line_elv+(Line_th)/2), AngularArc from point 0 over 3 centre=(0, 0, Line_elv+(Line_th)/2) angle=(PI) plane=XY, section rectangle width=TRL_SW height=Line_th)
  TRL15zSa.move(0, 0, 0)
  TRL15zSb [copper] = polyline(((1.5*TRL_SW+TRL_SS+(0))*sin(PI+(PI)), (1.5*TRL_SW+TRL_SS+(0))*cos(PI+(PI)), Line_elv+(Line_th)/2), AngularArc from point 0 over 3 centre=(0, 0, Line_elv+(Line_th)/2) angle=(PI) plane=XY, section rectangle width=TRL_SW height=Line_th)
  TRL15zSb.move(0, 0, 0)
  TRL15zSg [copper] = polyline(((TRL_SS/2+TRL_SW+(0))*sin(PI+(PI)), (TRL_SS/2+TRL_SW+(0))*cos(PI+(PI)), GND_elv+(GND_th)/2), AngularArc from point 0 over 3 centre=(0, 0, GND_elv+(GND_th)/2) angle=(PI) plane=XY, section rectangle width=TRL_SS+2*TRL_SW-0.1um height=GND_th)
  TRL15zSg.move(0, 0, 0)
  [TRL15z, TRL15zSa, TRL15zSb, TRL15zSg].rotate(axis=Z, angle=PI/2)
  [TRL15z, TRL15zSa, TRL15zSb, TRL15zSg].move(((TRL_SS+2*TRL_SW)-(TRL_SS+2*TRL_SW)/2), -SPL_Ld, 0)
  TRL16za [copper] = box(corner=((-TRL_W/2), 0, Line_elv), size=(TRL_W, TRL_SW+TRL_SS/2+TRL_W/2, Line_th))
  TRL16zb [copper] = box(corner=(-(TRL_SS/2+TRL_SW), TRL_SW+TRL_SS/2-TRL_W/2, Line_elv), size=(2*(TRL_SS/2+TRL_SW), TRL_W, Line_th))
  TRL16zSa [copper] = box(corner=(-(TRL_SS/2+TRL_SW), TRL_SW+TRL_SS, Line_elv), size=(2*(TRL_SS/2+TRL_SW), TRL_SW, Line_th))
  TRL16zSb [copper] = box(corner=(-(TRL_SS/2+TRL_SW), 0, Line_elv), size=(TRL_SW, TRL_SW, Line_th))
  TRL16zSc [copper] = box(corner=((TRL_SS/2), 0, Line_elv), size=(TRL_SW, TRL_SW, Line_th))
  TRL16zSg [copper] = box(corner=(-(TRL_SS/2+TRL_SW), 0, GND_elv), size=(2*(TRL_SS/2+TRL_SW), 2*(TRL_SW+TRL_SS/2), GND_th))
  [TRL16za, TRL16zb, TRL16zSa, TRL16zSb, TRL16zSc, TRL16zSg].rotate(axis=Z, angle=PI)
  [TRL16za, TRL16zb, TRL16zSa, TRL16zSb, TRL16zSc, TRL16zSg].move(-((TRL_SS+2*TRL_SW)), -2*SPL_Ld+TRL_SW, 0)
  TRL17za [copper] = box(corner=((-TRL_W/2), 0, Line_elv), size=(TRL_W, TRL_SW+TRL_SS/2+TRL_W/2, Line_th))
  TRL17zb [copper] = box(corner=(-(TRL_SS/2+TRL_SW), TRL_SW+TRL_SS/2-TRL_W/2, Line_elv), size=(2*(TRL_SS/2+TRL_SW), TRL_W, Line_th))
  TRL17zSa [copper] = box(corner=(-(TRL_SS/2+TRL_SW), TRL_SW+TRL_SS, Line_elv), size=(2*(TRL_SS/2+TRL_SW), TRL_SW, Line_th))
  TRL17zSb [copper] = box(corner=(-(TRL_SS/2+TRL_SW), 0, Line_elv), size=(TRL_SW, TRL_SW, Line_th))
  TRL17zSc [copper] = box(corner=((TRL_SS/2), 0, Line_elv), size=(TRL_SW, TRL_SW, Line_th))
  TRL17zSg [copper] = box(corner=(-(TRL_SS/2+TRL_SW), 0, GND_elv), size=(2*(TRL_SS/2+TRL_SW), 2*(TRL_SW+TRL_SS/2), GND_th))
  [TRL17za, TRL17zb, TRL17zSa, TRL17zSb, TRL17zSc, TRL17zSg].rotate(axis=Z, angle=0)
  [TRL17za, TRL17zb, TRL17zSa, TRL17zSb, TRL17zSc, TRL17zSg].move(((TRL_SS+2*TRL_SW)), 2*SPL_Ld-TRL_SW, 0)
  TRL18z [copper] = polyline(((TRL_SS/2+TRL_SW+(((TRL_SS+2*TRL_SW))))*sin(PI+(PI/2)), (TRL_SS/2+TRL_SW+(((TRL_SS+2*TRL_SW))))*cos(PI+(PI/2)), Line_elv+(Line_th)/2), AngularArc from point 0 over 3 centre=(0, 0, Line_elv+(Line_th)/2) angle=(PI/2) plane=XY, section rectangle width=TRL_W height=Line_th)
  TRL18z.move(0, 0, 0)
  TRL18zSa [copper] = polyline(((TRL_SW/2+(((TRL_SS+2*TRL_SW))))*sin(PI+(PI/2)), (TRL_SW/2+(((TRL_SS+2*TRL_SW))))*cos(PI+(PI/2)), Line_elv+(Line_th)/2), AngularArc from point 0 over 3 centre=(0, 0, Line_elv+(Line_th)/2) angle=(PI/2) plane=XY, section rectangle width=TRL_SW height=Line_th)
  TRL18zSa.move(0, 0, 0)
  TRL18zSb [copper] = polyline(((1.5*TRL_SW+TRL_SS+(((TRL_SS+2*TRL_SW))))*sin(PI+(PI/2)), (1.5*TRL_SW+TRL_SS+(((TRL_SS+2*TRL_SW))))*cos(PI+(PI/2)), Line_elv+(Line_th)/2), AngularArc from point 0 over 3 centre=(0, 0, Line_elv+(Line_th)/2) angle=(PI/2) plane=XY, section rectangle width=TRL_SW height=Line_th)
  TRL18zSb.move(0, 0, 0)
  TRL18zSg [copper] = polyline(((TRL_SS/2+TRL_SW+(((TRL_SS+2*TRL_SW))))*sin(PI+(PI/2)), (TRL_SS/2+TRL_SW+(((TRL_SS+2*TRL_SW))))*cos(PI+(PI/2)), GND_elv+(GND_th)/2), AngularArc from point 0 over 3 centre=(0, 0, GND_elv+(GND_th)/2) angle=(PI/2) plane=XY, section rectangle width=TRL_SS+2*TRL_SW-0.1um height=GND_th)
  TRL18zSg.move(0, 0, 0)
  [TRL18z, TRL18zSa, TRL18zSb, TRL18zSg].rotate(axis=Z, angle=-PI/2)
  [TRL18z, TRL18zSa, TRL18zSb, TRL18zSg].move(-((TRL_SS+2*TRL_SW)-(TRL_SS+2*TRL_SW)/2), SPL_Ld, 0)
  TRL19z [copper] = polyline(((TRL_SS/2+TRL_SW+(((TRL_SS+2*TRL_SW))))*sin(PI+(PI/2)), (TRL_SS/2+TRL_SW+(((TRL_SS+2*TRL_SW))))*cos(PI+(PI/2)), Line_elv+(Line_th)/2), AngularArc from point 0 over 3 centre=(0, 0, Line_elv+(Line_th)/2) angle=(PI/2) plane=XY, section rectangle width=TRL_W height=Line_th)
  TRL19z.move(0, 0, 0)
  TRL19zSa [copper] = polyline(((TRL_SW/2+(((TRL_SS+2*TRL_SW))))*sin(PI+(PI/2)), (TRL_SW/2+(((TRL_SS+2*TRL_SW))))*cos(PI+(PI/2)), Line_elv+(Line_th)/2), AngularArc from point 0 over 3 centre=(0, 0, Line_elv+(Line_th)/2) angle=(PI/2) plane=XY, section rectangle width=TRL_SW height=Line_th)
  TRL19zSa.move(0, 0, 0)
  TRL19zSb [copper] = polyline(((1.5*TRL_SW+TRL_SS+(((TRL_SS+2*TRL_SW))))*sin(PI+(PI/2)), (1.5*TRL_SW+TRL_SS+(((TRL_SS+2*TRL_SW))))*cos(PI+(PI/2)), Line_elv+(Line_th)/2), AngularArc from point 0 over 3 centre=(0, 0, Line_elv+(Line_th)/2) angle=(PI/2) plane=XY, section rectangle width=TRL_SW height=Line_th)
  TRL19zSb.move(0, 0, 0)
  TRL19zSg [copper] = polyline(((TRL_SS/2+TRL_SW+(((TRL_SS+2*TRL_SW))))*sin(PI+(PI/2)), (TRL_SS/2+TRL_SW+(((TRL_SS+2*TRL_SW))))*cos(PI+(PI/2)), GND_elv+(GND_th)/2), AngularArc from point 0 over 3 centre=(0, 0, GND_elv+(GND_th)/2) angle=(PI/2) plane=XY, section rectangle width=TRL_SS+2*TRL_SW-0.1um height=GND_th)
  TRL19zSg.move(0, 0, 0)
  [TRL19z, TRL19zSa, TRL19zSb, TRL19zSg].rotate(axis=Z, angle=PI/2)
  [TRL19z, TRL19zSa, TRL19zSb, TRL19zSg].move(((TRL_SS+2*TRL_SW)-(TRL_SS+2*TRL_SW)/2), -SPL_Ld, 0)
  TRL20z [copper] = box(corner=((-TRL_W/2), 0, Line_elv), size=(TRL_W, ((TRL_SS+2*TRL_SW)), Line_th))
  TRL20zSa [copper] = box(corner=(-((TRL_SS)/2+TRL_SW), 0, Line_elv), size=(TRL_SW, ((TRL_SS+2*TRL_SW)), Line_th))
  TRL20zSb [copper] = box(corner=(((TRL_SS)/2), 0, Line_elv), size=(TRL_SW, ((TRL_SS+2*TRL_SW)), Line_th))
  TRL20zSg [copper] = box(corner=(-((TRL_SS)/2+TRL_SW), 0, GND_elv), size=(TRL_SS+2*TRL_SW, ((TRL_SS+2*TRL_SW)), GND_th))
  [TRL20z, TRL20zSa, TRL20zSb, TRL20zSg].rotate(axis=Z, angle=PI/2)
  [TRL20z, TRL20zSa, TRL20zSb, TRL20zSg].move(((TRL_SS+2*TRL_SW)/2), -(SPL_Ld+1.5*(TRL_SS+2*TRL_SW)), 0)
  TRL21z [copper] = box(corner=((-TRL_W/2), 0, Line_elv), size=(TRL_W, ((TRL_SS+2*TRL_SW)), Line_th))
  TRL21zSa [copper] = box(corner=(-((TRL_SS)/2+TRL_SW), 0, Line_elv), size=(TRL_SW, ((TRL_SS+2*TRL_SW)), Line_th))
  TRL21zSb [copper] = box(corner=(((TRL_SS)/2), 0, Line_elv), size=(TRL_SW, ((TRL_SS+2*TRL_SW)), Line_th))
  TRL21zSg [copper] = box(corner=(-((TRL_SS)/2+TRL_SW), 0, GND_elv), size=(TRL_SS+2*TRL_SW, ((TRL_SS+2*TRL_SW)), GND_th))
  [TRL21z, TRL21zSa, TRL21zSb, TRL21zSg].rotate(axis=Z, angle=-PI/2)
  [TRL21z, TRL21zSa, TRL21zSb, TRL21zSg].move(-((TRL_SS+2*TRL_SW)/2), (SPL_Ld+1.5*(TRL_SS+2*TRL_SW)), 0)
  Port1Box [pec] = box(corner=(-(TRL_SS/2+TRL_SW/4), 0, GND_elv), size=((TRL_SS+TRL_SW/2), 1um, WP_h))
  Port1 = rectangle(corner=(-(TRL_SS/2+TRL_SW/4), 0, GND_elv), z_size=WP_h, x_size=(TRL_SS+TRL_SW/2))
  [Port1Box, Port1].rotate(axis=Z, angle=PI)
  [Port1Box, Port1].move(-(2*(TRL_SS+2*TRL_SW)), (SPL_Ld), 0)
  Port2Box [pec] = box(corner=(-(TRL_SS/2+TRL_SW/4), 0, GND_elv), size=((TRL_SS+TRL_SW/2), 1um, WP_h))
  Port2 = rectangle(corner=(-(TRL_SS/2+TRL_SW/4), 0, GND_elv), z_size=WP_h, x_size=(TRL_SS+TRL_SW/2))
  [Port2Box, Port2].rotate(axis=Z, angle=0)
  [Port2Box, Port2].move((2*(TRL_SS+2*TRL_SW)), -(SPL_Ld), 0)
  group TRL10z_Group = TRL10z, TRL10zCa, TRL10zCb, TRL10zSa, TRL10zSb, TRL10zSg
  group TRL11z_Group = TRL11z, TRL11zCa, TRL11zCb, TRL11zSa, TRL11zSb, TRL11zSg
  group TRL12z_Group = TRL12z, TRL12zSa, TRL12zSb, TRL12zSg
  group TRL13z_Group = TRL13z, TRL13zSa, TRL13zSb, TRL13zSg
  group TRL14z_Group = TRL14z, TRL14zSa, TRL14zSb, TRL14zSg
  group TRL15z_Group = TRL15z, TRL15zSa, TRL15zSb, TRL15zSg
  group TRL16z_Group = TRL16za, TRL16zb, TRL16zSa, TRL16zSb, TRL16zSc, TRL16zSg
  group TRL17z_Group = TRL17za, TRL17zb, TRL17zSa, TRL17zSb, TRL17zSc, TRL17zSg
  group TRL18z_Group = TRL18z, TRL18zSa, TRL18zSb, TRL18zSg
  group TRL19z_Group = TRL19z, TRL19zSa, TRL19zSb, TRL19zSg
  group TRL20z_Group = TRL20z, TRL20zSa, TRL20zSb, TRL20zSg
  group TRL21z_Group = TRL21z, TRL21zSa, TRL21zSb, TRL21zSg
boundaries and excitations:
  Rad1: Radiation Objects=Air
setups:
  Setup1: HfssDriven Frequency=2.4GHz MaxDeltaE=0.02 MaximumPasses=20 MinimumPasses=2 MinimumConvergedPasses=2 PercentRefinement=30 BasisOrder=1
    sweep Sweep1: 2.3GHz to 2.5GHz step 0.01GHz; Type=Discrete SaveFields
